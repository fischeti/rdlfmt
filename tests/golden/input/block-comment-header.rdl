/*******************************************************************************
 *  Copyright (c) Example Ltd. 2026
 *  All rights reserved.
 ******************************************************************************/

addrmap top {
    reg { field {} f; } r1; /* inline block */

    reg { field {} f; } r2;
};
